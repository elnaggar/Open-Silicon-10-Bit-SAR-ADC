* Open-Silicon-SAR-ADC
* Gulu, Ankur Gupta, Ahmed Elnaggar
* Author: Ahmed Elnaggar
* diff_cdac_opt_bootx - binary10_opt_r with a TRANSISTOR-LEVEL
* bootstrapped top-plate sampling switch (9 devices + a 1 pF MIM).
* Generated by make_boot_transistor.py; everything else, including
* the NMOS-only charge-injection dummy, is identical to
* diff_cdac_opt_r.spice.
*   NMOS-only top-plate switch, NMOS-only charge-injection dummy.
* Generated by make_robust.py. VCM is set at simulation time.

* ---------------------------------------------------------------
* Transistor-level bootstrapped sampling switch.
* Ports kept identical to top_nmos_switch so the array instances are
* unchanged. VCM is the analog input (top-plate sampling), VTOP the plate.
* See make_boot_transistor.py for the topology and the over-stress budget.
* ---------------------------------------------------------------
.subckt top_nmos_switch VTOP VCM_EN VCM_EN_B VCM VDD VSS
* bootstrap capacitor, real MIM: 22.2 x 22.2 um = 1.00 pF
Xcb tp bt cap_mim_2f0fF c_width=22.2e-6 c_length=22.2e-6

* --- hold: charge Cb to VDD, ground the bottom plate and the gate --------
* Two things about MP1, both found by simulation rather than by design.
* n-well on tp, not VDD: tp swings above VDD and a VDD well would
* Gate on gt, NOT on the clock. With the gate at VDD during track, tp rising
* past VDD + |Vth| makes MP1's drain its source and it turns back on, dumping
* the boost into the supply - measured, it clamped tp at 4.3 V and held the
* overdrive to 1.9 V instead of 3.6 V. Driving the gate from the boosted node
* makes Vsg = tp - gt = 0 during track, so it stays off.
XMP1 tp gt VDD tp pfet_03v3 L=0.28u W=4u nf=1 ad='int((nf+1)/2) * W/nf * 0.18u' as='int((nf+2)/2) * W/nf * 0.18u' pd='2*int((nf+1)/2) * (W/nf + 0.18u)' ps='2*int((nf+2)/2) * (W/nf + 0.18u)' nrd='0.18u / W' nrs='0.18u / W' sa=0 sb=0 sd=0
XMN1 bt VCM_EN_B VSS VSS nfet_03v3 L=0.28u W=4u nf=1 ad='int((nf+1)/2) * W/nf * 0.18u' as='int((nf+2)/2) * W/nf * 0.18u' pd='2*int((nf+1)/2) * (W/nf + 0.18u)' ps='2*int((nf+2)/2) * (W/nf + 0.18u)' nrd='0.18u / W' nrs='0.18u / W' sa=0 sb=0 sd=0
* MN2c cascodes MN2: while tracking, gt is at VIN+VDD and MN2's gate is at 0,
* which would be ~6 V of gate-drain stress. The cascode clamps nmid to
* VDD-Vth and splits it.
XMN2c gt VDD nmid VSS nfet_03v3 L=0.28u W=4u nf=1 ad='int((nf+1)/2) * W/nf * 0.18u' as='int((nf+2)/2) * W/nf * 0.18u' pd='2*int((nf+1)/2) * (W/nf + 0.18u)' ps='2*int((nf+2)/2) * (W/nf + 0.18u)' nrd='0.18u / W' nrs='0.18u / W' sa=0 sb=0 sd=0
XMN2 nmid VCM_EN_B VSS VSS nfet_03v3 L=0.28u W=4u nf=1 ad='int((nf+1)/2) * W/nf * 0.18u' as='int((nf+2)/2) * W/nf * 0.18u' pd='2*int((nf+1)/2) * (W/nf + 0.18u)' ps='2*int((nf+2)/2) * (W/nf + 0.18u)' nrd='0.18u / W' nrs='0.18u / W' sa=0 sb=0 sd=0

* --- track: bottom plate to the input, top plate to the gate -------------
XMN3 bt gt VCM VSS nfet_03v3 L=0.28u W=4u nf=1 ad='int((nf+1)/2) * W/nf * 0.18u' as='int((nf+2)/2) * W/nf * 0.18u' pd='2*int((nf+1)/2) * (W/nf + 0.18u)' ps='2*int((nf+2)/2) * (W/nf + 0.18u)' nrd='0.18u / W' nrs='0.18u / W' sa=0 sb=0 sd=0
XMP2 gt ngb tp tp pfet_03v3 L=0.28u W=4u nf=1 ad='int((nf+1)/2) * W/nf * 0.18u' as='int((nf+2)/2) * W/nf * 0.18u' pd='2*int((nf+1)/2) * (W/nf + 0.18u)' ps='2*int((nf+2)/2) * (W/nf + 0.18u)' nrd='0.18u / W' nrs='0.18u / W' sa=0 sb=0 sd=0

* ngb, the gate of MP2: follows `bt` while tracking and sits at VDD while
* holding. Driving it from bt rather than from VIN is what makes the boost
* start at every corner. bt begins each track phase at 0, so MP2 turns on with
* Vsg = VDD no matter how high the input is; taking ngb straight from VIN gave
* MP2 only Vsg = VDD - VIN = 0.71 V at ss / -40 C / 3.0 V, below |Vth| there,
* and the switch never boosted at all (measured overdrive -2.33 V). Once bt
* has risen to VIN the steady-state Vsg is back to VDD, so the oxide stress is
* still bounded.
XMN4 ngb VCM_EN bt VSS nfet_03v3 L=0.28u W=2u nf=1 ad='int((nf+1)/2) * W/nf * 0.18u' as='int((nf+2)/2) * W/nf * 0.18u' pd='2*int((nf+1)/2) * (W/nf + 0.18u)' ps='2*int((nf+2)/2) * (W/nf + 0.18u)' nrd='0.18u / W' nrs='0.18u / W' sa=0 sb=0 sd=0
XMP3 ngb VCM_EN VDD VDD pfet_03v3 L=0.28u W=2u nf=1 ad='int((nf+1)/2) * W/nf * 0.18u' as='int((nf+2)/2) * W/nf * 0.18u' pd='2*int((nf+1)/2) * (W/nf + 0.18u)' ps='2*int((nf+2)/2) * (W/nf + 0.18u)' nrd='0.18u / W' nrs='0.18u / W' sa=0 sb=0 sd=0

* --- the sampling device, identical geometry to the as-built switch ------
XMSW VTOP gt VCM VSS nfet_03v3 L=0.28u W=20u nf=4 ad='int((nf+1)/2) * W/nf * 0.18u' as='int((nf+2)/2) * W/nf * 0.18u' pd='2*int((nf+1)/2) * (W/nf + 0.18u)' ps='2*int((nf+2)/2) * (W/nf + 0.18u)' nrd='0.18u / W' nrs='0.18u / W' sa=0 sb=0 sd=0
.ends top_nmos_switch

* diff_cdac_opt_bootx — optimized variant of diff_cdac.spice
* Generated by make_optimized.py. Do not hand-edit; edit the
* generator or the as-built netlist instead.
* Changes:
.subckt diff_cdac_opt_bootx SW_P[9] SW_P[8] SW_P[7] SW_P[6] SW_P[5] SW_P[4] SW_P[3] SW_P[2] SW_P[1] SW_P[0] VOUT_P VCM_P VCM_N VOUT_N
+ SW_N[9] SW_N[8] SW_N[7] SW_N[6] SW_N[5] SW_N[4] SW_N[3] SW_N[2] SW_N[1] SW_N[0] VCM_EN VCM_EN_B VDD VSS
XLSB_dummy_n VOUT_N VSS cap_mim_2f0fF c_width=5e-6 c_length=5e-6
Xbo_n VOUT_N SW_N[0] cap_mim_2f0fF c_width=5e-6 c_length=5e-6
Xb1_n VOUT_N SW_N[1] cap_mim_2f0fF c_width=5e-6 c_length=5e-6 m=2
Xb2_n VOUT_N SW_N[2] cap_mim_2f0fF c_width=5e-6 c_length=5e-6 m=4
Xb3_n VOUT_N SW_N[3] cap_mim_2f0fF c_width=5e-6 c_length=5e-6 m=8
Xb4_n VOUT_N SW_N[4] cap_mim_2f0fF c_width=5e-6 c_length=5e-6 m=16
Xb5_n VOUT_N SW_N[5] cap_mim_2f0fF c_width=5e-6 c_length=5e-6 m=32
Xb6_n VOUT_N SW_N[6] cap_mim_2f0fF c_width=5e-6 c_length=5e-6 m=64
Xb7_n VOUT_N SW_N[7] cap_mim_2f0fF c_width=5e-6 c_length=5e-6 m=128
Xb8_n VOUT_N SW_N[8] cap_mim_2f0fF c_width=5e-6 c_length=5e-6 m=256
Xb9_n VOUT_N SW_N[9] cap_mim_2f0fF c_width=5e-6 c_length=5e-6 m=512
XLSB_dummy_p VOUT_P VSS cap_mim_2f0fF c_width=5e-6 c_length=5e-6
Xbo_p VOUT_P SW_P[0] cap_mim_2f0fF c_width=5e-6 c_length=5e-6
Xb1_p VOUT_P SW_P[1] cap_mim_2f0fF c_width=5e-6 c_length=5e-6 m=2
Xb2_p VOUT_P SW_P[2] cap_mim_2f0fF c_width=5e-6 c_length=5e-6 m=4
Xb3_p VOUT_P SW_P[3] cap_mim_2f0fF c_width=5e-6 c_length=5e-6 m=8
Xb4_p VOUT_P SW_P[4] cap_mim_2f0fF c_width=5e-6 c_length=5e-6 m=16
Xb5_p VOUT_P SW_P[5] cap_mim_2f0fF c_width=5e-6 c_length=5e-6 m=32
Xb6_p VOUT_P SW_P[6] cap_mim_2f0fF c_width=5e-6 c_length=5e-6 m=64
Xb7_p VOUT_P SW_P[7] cap_mim_2f0fF c_width=5e-6 c_length=5e-6 m=128
Xb8_p VOUT_P SW_P[8] cap_mim_2f0fF c_width=5e-6 c_length=5e-6 m=256
Xb9_p VOUT_P SW_P[9] cap_mim_2f0fF c_width=5e-6 c_length=5e-6 m=512
x1 VOUT_P VCM_EN VCM_EN_B VCM_P VDD VSS top_nmos_switch
XMN_dum_x1 VOUT_P VCM_EN_B VOUT_P VSS nfet_03v3 L=0.28u W=10u nf=4 ad='int((nf+1)/2) * W/nf * 0.18u' as='int((nf+2)/2) * W/nf * 0.18u' pd='2*int((nf+1)/2) * (W/nf + 0.18u)' ps='2*int((nf+2)/2) * (W/nf + 0.18u)' nrd='0.18u / W' nrs='0.18u / W' sa=0 sb=0 sd=0
x2 VOUT_N VCM_EN VCM_EN_B VCM_N VDD VSS top_nmos_switch
XMN_dum_x2 VOUT_N VCM_EN_B VOUT_N VSS nfet_03v3 L=0.28u W=10u nf=4 ad='int((nf+1)/2) * W/nf * 0.18u' as='int((nf+2)/2) * W/nf * 0.18u' pd='2*int((nf+1)/2) * (W/nf + 0.18u)' ps='2*int((nf+2)/2) * (W/nf + 0.18u)' nrd='0.18u / W' nrs='0.18u / W' sa=0 sb=0 sd=0
.ends

.subckt top_tg_switch VTOP VCM_EN VCM_EN_B VCM VDD VSS
XM1 VCM VCM_EN_B VTOP VDD pfet_03v3 L=0.28u W=50u nf=10 ad='int((nf+1)/2) * W/nf * 0.18u' as='int((nf+2)/2) * W/nf * 0.18u' pd='2*int((nf+1)/2) * (W/nf + 0.18u)' ps='2*int((nf+2)/2) * (W/nf + 0.18u)' nrd='0.18u / W' nrs='0.18u / W' sa=0 sb=0 sd=0
XM2 VTOP VCM_EN VCM VSS nfet_03v3 L=0.28u W=20u nf=4 ad='int((nf+1)/2) * W/nf * 0.18u' as='int((nf+2)/2) * W/nf * 0.18u' pd='2*int((nf+1)/2) * (W/nf + 0.18u)' ps='2*int((nf+2)/2) * (W/nf + 0.18u)' nrd='0.18u / W' nrs='0.18u / W' sa=0 sb=0 sd=0
.ends
